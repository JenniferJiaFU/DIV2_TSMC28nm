ADE simulation setup
Run mode: Single Run, Sweeps and Corners
Tests:
  jf_BASIC:tb_div2:1: DIV2/tb_div2/schematic, simulator spectre
Global variables:
  fin = 30G:2G:40G
